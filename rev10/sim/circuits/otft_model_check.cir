* otft_model_check.cir - cross-check trace2_otft.sub against otft_model.py
* Run from this folder:  ngspice -b otft_model_check.cir
* W/L = 200/8 um, source at 3.30 V. Printed |ID| should match this table
* (switch the .lib line to 'printed' for the second half):
* Python reference: |I_D| [A], W/L = 200/8 um, source at 3.30 V
* corner     VSG   VSD         |ID|
* lab       0.80  0.10   1.6176e-12
* lab       0.80  2.00   2.1000e-12
* lab       1.25  0.10   1.8301e-08
* lab       1.25  2.00   2.0216e-08
* lab       2.00  0.10   9.8391e-07
* lab       2.00  2.00   4.3656e-06
* lab       3.30  0.10   2.0588e-06
* lab       3.30  2.00   2.6871e-05
* printed   0.80  0.10   2.7177e-10
* printed   0.80  2.00   3.7743e-10
* printed   1.25  0.10   9.4686e-09
* printed   1.25  2.00   1.6238e-08
* printed   2.00  0.10   1.1202e-07
* printed   2.00  2.00   5.3112e-07
* printed   3.30  0.10   2.1181e-07
* printed   3.30  2.00   2.9617e-06

.include ../models/trace2_otft.sub
.lib ../models/trace2_otft.lib lab
VS s 0 3.30
VG g 0 0
VD d 0 0
X1 d g s potft W=200 L=8

.control
foreach vsg 0.8 1.25 2.0 3.3
  foreach vsd 0.1 2.0
    let vgv = 3.3 - $vsg
    let vdv = 3.3 - $vsd
    alter VG dc = $&vgv
    alter VD dc = $&vdv
    op
    let id = abs(i(VD))
    echo VSG=$vsg VSD=$vsd  ID=$&id
  end
end
.endc
.end
